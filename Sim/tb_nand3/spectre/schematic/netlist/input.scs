// Design: lab2024/tb_nand3
simulator lang=spectre
global 0 vdd!
include "/eda/cadence/ams/4.10/spectre/c35/soac/soac.scs"
include "/eda/cadence/ams/4.10/spectre/c35/soac/processOption.scs"
include "/eda/cadence/ams/4.10/spectre/c35/soac/cmos53.scs" section=cmostm
include "/eda/cadence/ams/4.10/spectre/c35/soac/res.scs" section=restm
include "/eda/cadence/ams/4.10/spectre/c35/soac/cap.scs" section=captm
include "/eda/cadence/ams/4.10/spectre/c35/soac/bip.scs" section=biptm
include "/eda/cadence/ams/4.10/spectre/c35/soac/ind.scs" section=indtm
include "/eda/cadence/ams/4.10/spectre/c35/soac/esddiode.scs" section=esddiodetm

// lab2024/NAND3/schematic
subckt NAND3 a b c out
    MN2 (net2 a 0 0) modn w=1u l=0.35u ng=1
    MN1 (net1 b net2 0) modn w=1u l=0.35u ng=1
    MN0 (out c net1 0) modn w=1u l=0.35u ng=1
    MP2 (out c vdd! vdd!) modp w=1u l=0.35u ng=1
    MP1 (out b vdd! vdd!) modp w=1u l=0.35u ng=1
    MP0 (out a vdd! vdd!) modp w=1u l=0.35u ng=1
ends NAND3

// lab2024/tb_nand3/schematic
I0 (net3 net2 net1 net4) NAND3
V0 (vdd! 0) vsource dc=3.3 type=dc
V6 (net1 0) vsource type=pulse val0=0 val1=3.3 period=2n rise=10p fall=10p width=1n
V4 (net2 0) vsource type=pulse val0=0 val1=3.3 period=2n rise=10p fall=10p width=1n
V1 (net3 0) vsource type=pulse val0=0 val1=3.3 period=4n delay=2n rise=10p fall=10p width=2n
C0 (net4 0) capacitor c=12f
simulatorOptions options reltol=100e-6 temp=27 homotopy=all limit=delta compatible=spice2 enable_pre_ver=yes ignorezerovar=yes
tran tran stop=10n errpreset=conservative
