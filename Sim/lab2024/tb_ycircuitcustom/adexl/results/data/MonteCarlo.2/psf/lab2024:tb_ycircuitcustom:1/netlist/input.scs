// Design: lab2024/tb_ycircuitcustom
simulator lang=spectre
global 0 vdd!
include "/eda/cadence/ams/4.10/spectre/c35/soac/soac.scs"
parameters temperature=27
include "/eda/cadence/ams/4.10/spectre/c35/soac/processOption.scs"
include "/eda/cadence/ams/4.10/spectre/c35/soac/cmos53.scs" section=cmostm
include "/eda/cadence/ams/4.10/spectre/c35/soac/res.scs" section=restm
include "/eda/cadence/ams/4.10/spectre/c35/soac/cap.scs" section=captm
include "/eda/cadence/ams/4.10/spectre/c35/soac/bip.scs" section=biptm
include "/eda/cadence/ams/4.10/spectre/c35/soac/ind.scs" section=indtm
include "/eda/cadence/ams/4.10/spectre/c35/soac/esddiode.scs" section=esddiodetm

// lab2024/ycircuitcustom/schematic
subckt ycircuitcustom A B C D out
parameters Wp=1u Wn=1u
    MPD (out D vdd! vdd!) modp w=Wp/1 l=0.35u ng=1
    MPC (out C net1 net1) modp w=(2*Wp)/1 l=0.35u ng=1
    MPB (net1 B vdd! vdd!) modp w=(2*Wp)/1 l=0.35u ng=1
    MPA (net1 A vdd! vdd!) modp w=(2*Wp)/1 l=0.35u ng=1
    MNC (net3 C 0 0) modn w=(2*Wn)/1 l=0.35u ng=1
    MNB (net2 B 0 0) modn w=(4*Wn)/1 l=0.35u ng=1
    MNA (net3 A net2 net2) modn w=(4*Wn)/1 l=0.35u ng=1
    MND (out D net3 net3) modn w=(2*Wn)/1 l=0.35u ng=1
ends ycircuitcustom

// lab2024/tb_ycircuitcustom/schematic
I4 (net4 net3 net2 net1 net5) ycircuitcustom Wp=1u Wn=1u
VD (net1 0) vsource type=pulse val0=0 val1=3.3 period=5n delay=0 rise=100p fall=100p width=1n
VC (net2 0) vsource type=pulse val0=0 val1=3.3 period=4n delay=1n rise=100p fall=100p width=1n
VB (net3 0) vsource type=pulse val0=0 val1=3.3 period=2n rise=100p fall=100p width=1n
VA (net4 0) vsource type=pulse val0=0 val1=3.3 period=4n delay=2n rise=100p fall=100p width=1n
C0 (net5 0) capacitor c=10f
V (vdd! 0) vsource dc=3.3 type=dc
simulatorOptions options reltol=100e-6 temp=27 homotopy=all limit=delta compatible=spice2 enable_pre_ver=yes ignorezerovar=yes
mc1 montecarlo numruns=100 seed=12345 variations=all sampling=standard donominal=yes scalarfile="../monteCarlo/mcdata" paramfile="../monteCarlo/mcparam" saveprocessparams=yes processparamfile="../monteCarlo/processParam" processscalarfile="../monteCarlo/processData" savemismatchparams=no dut=[ I4 ] paramdumpmode=yes savefamilyplots=yes savedatainseparatedir=yes wfseparation=yes {
tran tran stop=20n errpreset=conservative
}
save V:p
