// Design: lab2024/tb_invParam
simulator lang=spectre
global 0 vdd!
include "/eda/cadence/ams/4.10/spectre/c35/soac/soac.scs"
parameters temperature=27
include "/eda/cadence/ams/4.10/spectre/c35/soac/processOption.scs"
include "/eda/cadence/ams/4.10/spectre/c35/soac/cmos53.scs" section=cmostm
include "/eda/cadence/ams/4.10/spectre/c35/soac/res.scs" section=restm
include "/eda/cadence/ams/4.10/spectre/c35/soac/cap.scs" section=captm
include "/eda/cadence/ams/4.10/spectre/c35/soac/bip.scs" section=biptm
include "/eda/cadence/ams/4.10/spectre/c35/soac/ind.scs" section=indtm
include "/eda/cadence/ams/4.10/spectre/c35/soac/esddiode.scs" section=esddiodetm

// lab2024/invParam/schematic
subckt invParam in out
parameters Wn=1u Wp=1u
    MN0 (out in 0 0) modn w=Wn/1 l=0.35u ng=1
    MP0 (out in vdd! vdd!) modp w=Wp/1 l=0.35u ng=1
ends invParam

// lab2024/tb_invParam/schematic
V0 (vdd! 0) vsource dc=3.3 type=dc
C0 (net3 0) capacitor c=10f
V1 (net2 0) vsource type=pulse val0=0 val1=3.3 period=2n rise=100p fall=100p width=1n
I0 (net2 net3) invParam Wn=1u Wp=2u
simulatorOptions options reltol=100e-6 temp=27 homotopy=all limit=delta compatible=spice2 enable_pre_ver=yes ignorezerovar=yes
mc1 montecarlo numruns=100 seed=12345 variations=all sampling=standard donominal=yes scalarfile="../monteCarlo/mcdata" paramfile="../monteCarlo/mcparam" saveprocessparams=yes processparamfile="../monteCarlo/processParam" processscalarfile="../monteCarlo/processData" savemismatchparams=no dut=[ I0 ] paramdumpmode=yes savefamilyplots=yes savedatainseparatedir=yes wfseparation=yes {
tran tran stop=10n errpreset=conservative
}
save V0:p
