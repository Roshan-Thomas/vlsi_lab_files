// Design: lab2024/tb_ycircuit
simulator lang=spectre
global 0 vdd!
include "/eda/cadence/ams/4.10/spectre/c35/soac/soac.scs"
parameters temperature=27 Vsupply=3.3
include "/eda/cadence/ams/4.10/spectre/c35/soac/res.scs" section=restm
include "/eda/cadence/ams/4.10/spectre/c35/soac/bip.scs" section=biptm
include "/eda/cadence/ams/4.10/spectre/c35/soac/cap.scs" section=captm
include "/eda/cadence/ams/4.10/spectre/c35/soac/esddiode.scs" section=esddiodetm
include "/eda/cadence/ams/4.10/spectre/c35/soac/ind.scs" section=indtm
include "/eda/cadence/ams/4.10/spectre/c35/soac/cmos53.scs" section=cmosws
include "/eda/cadence/ams/4.10/spectre/c35/soac/processOption.scs"

// lab2024/ycircuit/schematic
subckt ycircuit A B C D out
parameters Wp=1u Wn=1u
    MPD (out D vdd! vdd!) modp w=Wp/1 l=0.35u ng=1
    MPC (out C net1 net1) modp w=Wp/1 l=0.35u ng=1
    MPB (net1 B vdd! vdd!) modp w=Wp/1 l=0.35u ng=1
    MPA (net1 A vdd! vdd!) modp w=Wp/1 l=0.35u ng=1
    MNC (net3 C 0 0) modn w=Wn/1 l=0.35u ng=1
    MNB (net2 B 0 0) modn w=Wn/1 l=0.35u ng=1
    MNA (net3 A net2 net2) modn w=Wn/1 l=0.35u ng=1
    MND (out D net3 net3) modn w=Wn/1 l=0.35u ng=1
ends ycircuit

// lab2024/tb_ycircuit/schematic
I0 (net4 net3 net2 net1 net5) ycircuit Wp=1u Wn=1u
VD (net1 0) vsource type=pulse val0=0 val1=3.3 period=2n delay=5n rise=100p fall=100p width=1n
VC (net2 0) vsource type=pulse val0=0 val1=3.3 period=4n delay=3n rise=100p fall=100p width=1n
VB (net3 0) vsource type=pulse val0=0 val1=3.3 period=2n rise=100p fall=100p width=1n
VA (net4 0) vsource type=pulse val0=0 val1=3.3 period=20n rise=100p fall=100p width=10n
C0 (net5 0) capacitor c=10f
V (vdd! 0) vsource dc=3.3 type=dc
simulatorOptions options reltol=100e-6 temp=27 homotopy=all limit=delta compatible=spice2 enable_pre_ver=yes ignorezerovar=yes
mc1 montecarlo numruns=200 seed=12345 variations=all sampling=lds donominal=no scalarfile="../monteCarlo/mcdata" paramfile="../monteCarlo/mcparam" saveprocessparams=no savemismatchparams=no savefamilyplots=yes savedatainseparatedir=yes wfseparation=yes {
tran tran stop=20n errpreset=conservative
}
save V:p
