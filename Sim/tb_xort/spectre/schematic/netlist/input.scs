// Design: lab2024/tb_xort
simulator lang=spectre
global 0 vdd!
include "/eda/cadence/ams/4.10/spectre/c35/soac/soac.scs"
include "/eda/cadence/ams/4.10/spectre/c35/soac/processOption.scs"
include "/eda/cadence/ams/4.10/spectre/c35/soac/cmos53.scs" section=cmostm
include "/eda/cadence/ams/4.10/spectre/c35/soac/res.scs" section=restm
include "/eda/cadence/ams/4.10/spectre/c35/soac/cap.scs" section=captm
include "/eda/cadence/ams/4.10/spectre/c35/soac/bip.scs" section=biptm
include "/eda/cadence/ams/4.10/spectre/c35/soac/ind.scs" section=indtm
include "/eda/cadence/ams/4.10/spectre/c35/soac/esddiode.scs" section=esddiodetm

// lab2024/invParam/schematic
subckt invParam in out
parameters Wn=1u Wp=1u
    MN0 (out in 0 0) modn w=Wn/1 l=0.35u ng=1
    MP0 (out in vdd! vdd!) modp w=Wp/1 l=0.35u ng=1
ends invParam

// lab2024/xort/schematic
subckt xort A B out
parameters Wp=1u Wn=1u
    MP1 (net3 net2 B B) modp w=Wp/1 l=0.35u ng=1
    MP0 (A B out A) modp w=Wp/1 l=0.35u ng=1
    MN1 (net3 net2 net1 net1) modn w=Wn/1 l=0.35u ng=1
    MN0 (A net1 out out) modn w=Wn/1 l=0.35u ng=1
    I0 (B net1) invParam Wn=1u Wp=1u
ends xort

// lab2024/tb_xort/schematic
I0 (net2 net1 net3) xort Wp=1u Wn=1u
C0 (net3 0) capacitor c=1f
VB (net1 0) vsource type=pulse val0=3.3 val1=0 period=2n rise=100p fall=100p width=1n
VA (net2 0) vsource type=pulse val0=3.3 val1=0 period=10n rise=100p fall=100p width=5n
V (vdd! 0) vsource dc=3.3 type=dc
simulatorOptions options reltol=100e-6 temp=27 homotopy=all limit=delta compatible=spice2 enable_pre_ver=yes ignorezerovar=yes
tran tran stop=10n errpreset=conservative
