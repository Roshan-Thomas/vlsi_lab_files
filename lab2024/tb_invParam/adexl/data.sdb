ADE simulation setup
Run mode: Single Run, Sweeps and Corners
Tests:
  lab2024:tb_invParam:1: lab2024/tb_invParam/schematic, simulator spectre
Corners (nominal off):
  model folders: /eda/cadence/ams/4.10/spectre/c35/soac
  every corner: /eda/cadence/ams/4.10/spectre/c35/soac/res.scs[restm], /eda/cadence/ams/4.10/spectre/c35/soac/bip.scs[biptm], /eda/cadence/ams/4.10/spectre/c35/soac/cap.scs[captm], /eda/cadence/ams/4.10/spectre/c35/soac/esddiode.scs[esddiodetm], /eda/cadence/ams/4.10/spectre/c35/soac/ind.scs[indtm], /eda/cadence/ams/4.10/spectre/c35/soac/processOption.scs
  C35B4_corner001: Vsupply=3.3; temperature=27; cmos53.scs[cmostm]
  C35B4_corner002: Vsupply=3.3; temperature=27; cmos53.scs[cmoswp]
  C35B4_corner003: Vsupply=3.3; temperature=85; cmos53.scs[cmoswp]
  C35B4_corner004: Vsupply=3.3; temperature=27; cmos53.scs[cmosws]
  C35B4_corner005: Vsupply=3.3; temperature=85; cmos53.scs[cmosws]
  C35B4_corner006: Vsupply=3.3; temperature=27; cmos53.scs[cmoswo]
  C35B4_corner007: Vsupply=3.3; temperature=85; cmos53.scs[cmoswo]
  C35B4_corner008: Vsupply=3.3; temperature=27; cmos53.scs[cmoswz]
  C35B4_corner009: Vsupply=3.3; temperature=85; cmos53.scs[cmoswz]
