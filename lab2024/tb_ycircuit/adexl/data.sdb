ADE simulation setup
Run mode: Monte Carlo Sampling
Tests:
  lab2024:tb_ycircuit:1: lab2024/tb_ycircuit/schematic, simulator spectre
    Outputs: delay(?wf1 VT("/net3") ?value1 1.65 ?edge1 "falling" ?nth1 2 ?td1 0.0 ?wf2 VT("/net5") ?value2 1.65 ?edge2 "rising" ?nth2 2 ?td2 nil ?stop nil ?multiple nil)
Corners (all switched off):
  model folders: /eda/cadence/ams/4.10/spectre/c35/soac
  every corner: /eda/cadence/ams/4.10/spectre/c35/soac/res.scs[restm], /eda/cadence/ams/4.10/spectre/c35/soac/bip.scs[biptm], /eda/cadence/ams/4.10/spectre/c35/soac/cap.scs[captm], /eda/cadence/ams/4.10/spectre/c35/soac/esddiode.scs[esddiodetm], /eda/cadence/ams/4.10/spectre/c35/soac/ind.scs[indtm], /eda/cadence/ams/4.10/spectre/c35/soac/processOption.scs
  C35B4_corner001: temperature=27; Vsupply=3.3; cmos53.scs[cmostm]
  C35B4_corner002: temperature=27; Vsupply=3.3; cmos53.scs[cmoswp]
  C35B4_corner003: temperature=27; Vsupply=3.3; cmos53.scs[cmosws]
  C35B4_corner004: temperature=27; Vsupply=3.3; cmos53.scs[cmoswo]
  C35B4_corner005: temperature=27; Vsupply=3.3; cmos53.scs[cmoswz]
Specs:
  lab2024:tb_ycircuit:1 / Op_Region: < 1
  lab2024:tb_ycircuit:1 / delay(?wf1 VT("/net3") ?value1 1.65 ?edge1 "falling" ?nth1 2 ?td1 0.0 ?wf2 VT("/net5") ?value2 1.65 ?edge2 "rising" ?nth2 2 ?td2 nil ?stop nil ?multiple nil): < 217.115
Monte Carlo Sampling options: ignoremode=nominal, mcmethod=all, mcnumpoints=200, parasiticanalysis=0
